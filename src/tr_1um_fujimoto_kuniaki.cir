* Strict-port aligned reference netlist for TR-1um OpenSUSI
* Top/subcircuit pin order aligned with the KLayout-extracted netlist.

.subckt tr_1um_fujimoto_kuniaki P1 P10 P11 P12 P13 P14 P15 P2 P3 P4 P5 P6 P7 P9 VDD VSS
x1 P2 P9 P12 P6 P10 P11 P13 P14 P4 P15 P7 P1 P3 P5 VDD VSS OSS_FRAME
.ends tr_1um_fujimoto_kuniaki

.subckt OSS_FRAME P2 P9 P12 P6 P10 P11 P13 P14 P4 P15 P7 P1 P3 P5 VDD VSS
x1  P2  VDD VSS OSS_ESD_5V_ANA
x2  P9  VDD VSS OSS_ESD_5V_ANA
x3  P12 VDD VSS OSS_ESD_5V_ANA
x4  P6  VDD VSS OSS_ESD_5V_ANA
x5  P10 VDD VSS OSS_ESD_5V_ANA
x6  P11 VDD VSS OSS_ESD_5V_ANA
x7  P13 VDD VSS OSS_ESD_5V_ANA
x8  P14 VDD VSS OSS_ESD_5V_ANA
x9  P4  VDD VSS OSS_ESD_5V_ANA
x10 P15 VDD VSS OSS_ESD_5V_ANA
x11 P7  VDD VSS OSS_ESD_5V_ANA
x12 P1  VDD VSS OSS_ESD_5V_ANA
x13 P3  VDD VSS OSS_ESD_5V_ANA
x14 P5  VDD VSS OSS_ESD_5V_ANA
x19 VDD VSS OSS_ESD_5V_VDD
x20 VDD VSS OSS_ESD_5V_VSS
.ends OSS_FRAME

.subckt OSS_ESD_5V_VDD VDD VSS
MXM1 VDD VDD VDD VDD PMOS w=500u l=2u
MXM2 VDD VSS VSS VSS NMOSE w=500u l=2u
.ends OSS_ESD_5V_VDD

.subckt OSS_ESD_5V_VSS VDD VSS
MXM1 VSS VDD VDD VDD PMOS w=500u l=2u
MXM2 VSS VSS VSS VSS NMOSE w=500u l=2u
.ends OSS_ESD_5V_VSS

.subckt OSS_ESD_5V_ANA PAD VDD VSS
MXM1 PAD VDD VDD VDD PMOS w=500u l=2u
MXM2 PAD VSS VSS VSS NMOSE w=500u l=2u
.ends OSS_ESD_5V_ANA
